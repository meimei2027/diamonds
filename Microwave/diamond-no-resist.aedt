# Ansys Electronics Desktop project, version 2025.2
project variables:
  $smawidth = 3.3mm
  $copperthickness = 0.018mm
  $substratethickness = 1.6mm
  $lambda4 = 27mm
  $widthy = 70mm
  $taperextra = 0.05mm
  $tracelength = 0mm
  $tracewidth = 0.54mm
  $tracecenterx = 0.05mm+$tracewidth/2
  $resistthickness = 0.03mm
materials:
  vacuum: permittivity=1
  Isola FR408HR: permittivity=3.68 dielectric_loss_tangent=0.0092
  air: permittivity=1.0006 permeability=1.0000004
  FR4_epoxy: permittivity=4.3 dielectric_loss_tangent=0.03
  copper: permeability=0.999991 conductivity=58000000
  solder-resist: permittivity=3.4 dielectric_loss_tangent=0.025 delta_H_freq=2800000000
  SolderMask: permittivity=4.3 dielectric_loss_tangent=0.025

design HFSSDesign1 (HFSS, HFSS Terminal Network, model units mm)
geometry:
  substrate [FR4_epoxy] = box(corner=(-12.7mm, -30mm+$tracelength, 0mm), size=(25.4mm, $widthy-$tracelength, -$substratethickness))
  bigring [copper, solve inside] = cylinder(axis=Z, base_centre=(0mm, 0mm, 0mm), radius=7mm, height=$copperthickness)
  smallring = cylinder(axis=Z, base_centre=(0mm, 3.9mm, 0mm), radius=0.5mm, height=$copperthickness)
  bigring.subtract(smallring)
  gap = box(corner=(-0.05mm, -7mm, 0mm), size=(0.1mm, (7+3.9) mm, $copperthickness))
  bigring.subtract(gap)
  Polyline1 = polyline(z=0mm, xy: ($tracecenterx-$tracewidth/2, (-7mm+$taperextra)) ($tracecenterx+$tracewidth/2, -7mm+$taperextra) ($tracecenterx+$smawidth/2, (-23-7) mm) ($tracecenterx-$smawidth/2, (-23-7) mm) ($tracecenterx-$tracewidth/2, (-7mm+$taperextra)), closed, covered)
  line = Polyline1.detach(Polyline1.face(at (0.32, -18.475, 0)))
  line.sweep_along_vector((0mm, 0mm, $copperthickness))
  bigring.unite(line)
  ground = rectangle(corner=(-12.7mm, -30mm+$tracelength, -1.6mm), x_size=25.4mm, y_size=$widthy-$tracelength)
  radbox [air] = box(corner=(-((25.4+54)/2) mm, -30mm, -$lambda4), size=((25.4+54) mm, $widthy+$lambda4, $lambda4 *2))
  plane Plane1 = base (0mm, 0mm, (0.03+0.5) mm) normal (0mm, 0mm, 1mm)
  port1 = rectangle(corner=($tracecenterx-$smawidth*5, -30mm, -$substratethickness), z_size=$substratethickness*10, x_size=$smawidth*10)
  resist = box(corner=(-12.7mm, -30mm+$tracelength, 0), size=(25.4mm, $widthy-$tracelength, $copperthickness))
  bigring_2 = bigring.copy()
  resist.subtract(bigring_2)
  resist2 [SolderMask] = box(corner=(-12.7mm, -30mm+$tracelength, $copperthickness), size=(25.4mm, $widthy-$tracelength, $resistthickness-$copperthickness))
  resist2.unite(resist)
boundaries and excitations:
  ground: Perfect E Objects=ground
  antenna: Perfect E Objects=bigring
  Rad1: Radiation Faces=radbox.face(+x, +z, -x, +y, -z)
  1: Wave Port Objects=port1 WavePortType=Modal NumModes=1 Modes{Mode1{IntLine{(0.32, -30, 14.4) -> (0.32, -30, -1.6)} CharImp=Zpi RenormImp=50ohm}}
mesh:
  Length1: LengthBased Objects=bigring MaxLength=1.5mm
  Length2: LengthBased RefineInside Objects=resist2 MaxLength=5mm
  initial mesh: GlobalSurfApproximation{CurvedSurfaceApproxChoice=UseSlider SliderMeshSettings=7} GlobalCurvilinear{Apply} DynamicSurfaceResolution
setups:
  Setup1: HfssDriven Frequency=2.9GHz MaxDeltaS=0.01 MaximumPasses=6 MinimumPasses=1 MinimumConvergedPasses=1 PercentRefinement=30 BasisOrder=1 PortAccuracy=2 DrivenSolverType="Direct Solver"
    sweep Sweep: 2GHz to 4GHz, 200 points; Type=Interpolating SaveFields InterpTolerance=0.5 InterpMaxSolns=250 PassivityErrorTolerance=0.0001
source amplitudes:
  1:1: 1W 0deg
optimetrics:
  SensitivitySetup1: Sensitivity MaxIterations=10 Primary_Goal=-1 PrimaryError=0.0001
    calculate dB(St(1,1)) on Setup1 : Sweep at Freq 2.87437185929648GHz
field calculator expressions:
  test4 = <Hx,Hy,Hz> | Scalar_Function(FuncValue='Phase') | AtPhase | Normal | Dot
  test5 = test4 | Abs
field plots:
  test51: NamedExpr over a plane on Setup1 : Sweep at Freq=2.875GHz Phase=0deg
reports:
  S Parameter Plot1: dB(S(1,1)) vs Freq on Setup1 : Sweep; markers m1 at 2.6733668GHz, m2 at 2.8643216GHz, m3 at 2.8341709GHz, m4 at 2.8442211GHz, m5 at 2.8442211GHz
  Z Parameter Plot1: re(Z(1,1)), im(Z(1,1)) vs Freq on Setup1 : Sweep; markers m1 at 2.8140704GHz, m2 at 2.8040201GHz, m3 at 2.7839196GHz, m4 at 2.7939698GHz, m5 at 2.7939698GHz

# Ansys Electronics Desktop project, version 2025.2
project variables:
  $smawidth = 3.3mm
  $tracecenterx = 0.32mm
  $copperthickness = 0.5mm
materials:
  vacuum: permittivity=1
  Isola FR408HR: permittivity=3.68 dielectric_loss_tangent=0.0092
  air: permittivity=1.0006 permeability=1.0000004
  FR4_epoxy: permittivity=4.4 dielectric_loss_tangent=0.02
  copper: permeability=0.999991 conductivity=58000000

design HFSSDesign1 (HFSS, HFSS Terminal Network, model units mm)
geometry:
  substrate [FR4_epoxy] = box(corner=(-12.7mm, -30mm, 0mm), size=(25.4mm, 50.8mm, -1.6mm))
  bigring [copper, solve inside] = cylinder(axis=Z, base_centre=(0mm, 0mm, 0mm), radius=7mm, height=$copperthickness)
  smallring = cylinder(axis=Z, base_centre=(0mm, 3.9mm, 0mm), radius=0.5mm, height=$copperthickness)
  bigring.subtract(smallring)
  gap = box(corner=(-0.05mm, -7mm, 0mm), size=(0.1mm, (7+3.9) mm, $copperthickness))
  bigring.subtract(gap)
  Polyline1 = polyline(z=0mm, xy: ((0.32-0.27) mm, (-7+0.1) mm) ((0.32+0.27) mm, (-7+0.1) mm) ((0.32+1.65) mm, (-23-7) mm) ((0.32-1.65) mm, (-23-7) mm) ((0.32-0.27) mm, (-7+0.1) mm), closed, covered)
  line = Polyline1.detach(Polyline1.face(at (0.32, -18.45, 0)))
  line.sweep_along_vector((0mm, 0mm, $copperthickness))
  bigring.unite(line)
  ground = rectangle(corner=(-12.7mm, 20.8mm, -1.6mm), x_size=25.4mm, y_size=-50.8mm)
  radbox [air] = box(corner=(-17mm, -33mm, -5mm), size=(34mm, (50.8+3) mm, 20mm))
  port1 [non-model] = rectangle(corner=($tracecenterx-$smawidth/2, -30mm, -1.6mm), z_size=(1.6+0.018) mm, x_size=3.3mm)
  plane Plane1 = base (0mm, 0mm, 0.05mm) normal (0mm, 0mm, 1mm)
boundaries and excitations:
  ground: Perfect E Objects=ground
  antenna: Perfect E Objects=bigring
  radbox: Radiation Objects=radbox
setups:
  Setup1: HfssDriven Frequency=2.8GHz MaxDeltaE=0.1 MaximumPasses=6 MinimumPasses=1 MinimumConvergedPasses=1 PercentRefinement=30 BasisOrder=1 DrivenSolverType="Direct Solver"
    sweep Sweep: 1GHz to 5GHz, 50 points; Type=Interpolating InterpTolerance=0.5 InterpMaxSolns=250 PassivityErrorTolerance=0.0001
field plots:
  Mag_H1, Mag_H2: H Field over a plane on Setup1 : LastAdaptive at Freq=2.8GHz Phase=0deg
reports:
  S Parameter Plot1: dB(S(1,1)) vs Freq on Setup1 : Sweep

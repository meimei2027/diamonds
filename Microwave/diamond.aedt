# Ansys Electronics Desktop project, version 2025.2
project variables:
  $smawidth = 3.3mm
  $tracecenterx = 0.32mm
  $copperthickness = 0.018mm
  $substratethickness = 1.6mm
  $lambda4 = 27mm
  $widthy = 50.8mm
  $taperextra = 0.1mm
  $endtaper = 0.54mm
materials:
  vacuum: permittivity=1
  Isola FR408HR: permittivity=3.68 dielectric_loss_tangent=0.0092
  air: permittivity=1.0006 permeability=1.0000004
  FR4_epoxy: permittivity=4.4 dielectric_loss_tangent=0.02
  copper: permeability=0.999991 conductivity=58000000
  solder-resist: permittivity=4.3 dielectric_loss_tangent=0.025

design HFSSDesign1 (HFSS, HFSS Terminal Network, model units mm)
geometry:
  substrate [FR4_epoxy] = box(corner=(-12.7mm, -30mm, 0mm), size=(25.4mm, 50.8mm, -$substratethickness))
  bigring = cylinder(axis=Z, base_centre=(0mm, 0mm, 0mm), radius=7mm, height=$copperthickness)
  smallring = cylinder(axis=Z, base_centre=(0mm, 3.9mm, 0mm), radius=0.5mm, height=$copperthickness)
  bigring.subtract(smallring)
  gap = box(corner=(-0.05mm, -7mm, 0mm), size=(0.1mm, (7+3.9) mm, $copperthickness))
  bigring.subtract(gap)
  Polyline1 = polyline(z=0mm, xy: ($tracecenterx-$endtaper/2, -7mm) ($tracecenterx+$endtaper/2, -7mm) ($tracecenterx+$smawidth/2, (-23-7) mm) ($tracecenterx-$smawidth/2, (-23-7) mm) ($tracecenterx-$endtaper/2, -7mm), closed, covered)
  line = Polyline1.detach(Polyline1.face(at (0.32, -18.5, 0)))
  line.sweep_along_vector((0mm, 0mm, $copperthickness))
  bigring.unite(line)
  ground = rectangle(corner=(-12.7mm, 20.8mm, -1.6mm), x_size=25.4mm, y_size=-50.8mm)
  radbox [air] = box(corner=(-((25.4+54)/2) mm, -30mm, -$lambda4), size=((25.4+54) mm, (50.8+27) mm, $lambda4 *2))
  plane Plane1 = base (0mm, 0mm, 0.05mm) normal (0mm, 0mm, 1mm)
  port1 = rectangle(corner=($tracecenterx-$smawidth*5, -30mm, -$substratethickness), z_size=$substratethickness*10, x_size=$smawidth*10)
  connection [copper] = box(corner=($tracecenterx-$endtaper/2, -7mm, 0mm), size=($endtaper, 0.5mm, $copperthickness))
  connection.unite(bigring)
boundaries and excitations:
  radbox: Radiation Faces=radbox.face(+x, +z, -z, -x, +y)
  ground: Perfect E Objects=ground
  antenna: Perfect E Objects=connection
  1: Wave Port Objects=port1 WavePortType=Modal NumModes=1 Modes{Mode1{IntLine{(0.32, -30, 14.4) -> (0.32, -30, -1.6)} CharImp=Zpi RenormImp=50ohm}}
setups:
  Setup1: HfssDriven Frequency=2.8GHz MaxDeltaS=0.01 MaximumPasses=10 MinimumPasses=1 MinimumConvergedPasses=1 PercentRefinement=30 BasisOrder=1 PortAccuracy=2 DrivenSolverType="Direct Solver"
    sweep Sweep: 2.5GHz to 5GHz, 200 points; Type=Fast SaveFields
source amplitudes:
  1:1: 1W 0deg
field plots:
  Mag_H1, Mag_H2: H Field over a plane on Setup1 : LastAdaptive at Freq=2.8GHz Phase=0deg
reports:
  S Parameter Plot1: dB(S(1,1)) vs Freq on Setup1 : Sweep; markers m1 at 2.9396985GHz, m2 at 2.6130653GHz, m3 at 3.4296482GHz, m4 at 2.9648241GHz

# Ansys Electronics Desktop project, version 2025.2
project variables:
  $smawidth = 0.54mm
  $copperthickness = 0.018mm
  $substratethickness = 1.6mm
  $lambda4 = 27mm
  $widthy = 70mm
  $taperextra = 0.1mm
  $tracelength = 0mm
  $tracewidth = 0.54mm
  $tracecenterx = 0.05mm+$tracewidth/2
materials:
  vacuum: permittivity=1
  Isola FR408HR: permittivity=3.68 dielectric_loss_tangent=0.0092
  air: permittivity=1.0006 permeability=1.0000004
  FR4_epoxy: permittivity=4.3 dielectric_loss_tangent=0.03
  copper: permeability=0.999991 conductivity=58000000
  solder-resist: permittivity=3.4 dielectric_loss_tangent=0.025 delta_H_freq=2800000000
  SolderMask: permittivity=3.1 dielectric_loss_tangent=0.035

design HFSSDesign1 (HFSS, HFSS Terminal Network, model units mm)
geometry:
  substrate [FR4_epoxy] = box(corner=(-12.7mm, -30mm+$tracelength, 0mm), size=(25.4mm, $widthy-$tracelength, -$substratethickness))
  bigring [copper, solve inside] = cylinder(axis=Z, base_centre=(0mm, 0mm, 0mm), radius=7mm, height=$copperthickness)
  smallring = cylinder(axis=Z, base_centre=(0mm, 3.9mm, 0mm), radius=0.5mm, height=$copperthickness)
  bigring.subtract(smallring)
  gap = box(corner=(-0.05mm, -7mm, 0mm), size=(0.1mm, (7+3.9) mm, $copperthickness))
  bigring.subtract(gap)
  Polyline1 = polyline(z=0mm, xy: ($tracecenterx-$tracewidth/2, (-7mm+$taperextra)) ($tracecenterx+$tracewidth/2, -7mm+$taperextra) ($tracecenterx+$smawidth/2, (-0.5-7) mm) ($tracecenterx-$smawidth/2, (-0.5-7) mm) ($tracecenterx-$tracewidth/2, (-7mm+$taperextra)), closed, covered)
  line = Polyline1.detach(Polyline1.face(at (0.32, -7.2, 0)))
  line.sweep_along_vector((0mm, 0mm, $copperthickness))
  bigring.unite(line)
  ground = rectangle(corner=(-12.7mm, -30mm+$tracelength, -1.6mm), x_size=25.4mm, y_size=$widthy-$tracelength)
  radbox [air] = box(corner=(-((25.4+54)/2) mm, -30mm, -$lambda4), size=((25.4+54) mm, $widthy+$lambda4, $lambda4 *2))
  plane Plane1 = base (0mm, 0mm, 0.05mm) normal (0mm, 0mm, 1mm)
boundaries and excitations:
  ground: Perfect E Objects=ground
  antenna: Perfect E Objects=bigring
  radbox: Radiation Objects=radbox
mesh:
  initial mesh: GlobalCurvilinear{Apply}
setups:
  Setup1: HfssDriven Frequency=2.8GHz MaxDeltaE=0.1 MaximumPasses=6 MinimumPasses=1 MinimumConvergedPasses=1 PercentRefinement=30 BasisOrder=1 DrivenSolverType="Direct Solver"
    sweep Sweep: 2GHz to 4GHz, 200 points; Type=Fast SaveFields
field plots:
  Mag_H1: H Field over a plane on Setup1 : LastAdaptive at Freq=2.8GHz Phase=0deg
reports:
  S Parameter Plot1: dB(S(1,1)) vs Freq on Setup1 : Sweep; markers m1 at 3.0552764GHz, m2 at 3.0150754GHz
  Z Parameter Plot1: re(Z(1,1)), im(Z(1,1)) vs Freq on Setup1 : Sweep; markers m1 at 2.8140704GHz, m2 at 2.8040201GHz, m3 at 2.7839196GHz, m4 at 2.7939698GHz, m5 at 2.7939698GHz

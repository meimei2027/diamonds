# Ansys Electronics Desktop project, version 2025.2
project variables:
  $copperthickness = 1mm
  $r2 = 2.4mm
  $r1 = 1.2mm
  $gr = 0.2mm
  $w = 1mm
  $ringwidth = $r2-$gr-$r1
  $gs = 0.4mm
  $x_arc = sqrt(($r1+$ringwidth)^2- ($gs/2)^2) meter
materials:
  vacuum: permittivity=1

design HFSSDesign1 (HFSS, HFSS Terminal Network, model units mm)
geometry:
  Box1 [vacuum] = box(corner=(-10mm, -10mm, 0mm), size=(20mm, 20mm, 0.2mm))
  outer_ring [vacuum] = cylinder(axis=Z, base_centre=(0mm, 0mm, 0mm), radius=$r2+$ringwidth, height=$copperthickness)
  outer_ring_cutout = cylinder(axis=Z, base_centre=(0mm, 0mm, 0mm), radius=$r2, height=$copperthickness)
  outer_ring.subtract(outer_ring_cutout)
  inner_ring [vacuum] = cylinder(axis=Z, base_centre=(0mm, 0mm, 0mm), radius=$r1+$ringwidth, height=$copperthickness)
  inner_ring_cutout = cylinder(axis=Z, base_centre=(0mm, 0mm, 0mm), radius=$r1, height=$copperthickness)
  inner_ring.subtract(inner_ring_cutout)
  gap_inner [vacuum] = polyline(z=0mm, xy: (0mm, 0mm) ($x_arc, $gs/2) ($x_arc, -$gs/2) (0mm, 0mm), closed, covered)
  gap_inner.sweep_along_vector((0mm, 0mm, $copperthickness))
  gap_inner1 [vacuum] = polyline(z=0mm, xy: (0mm, 0mm) ($x_arc, $gs/2) ($x_arc, -$gs/2) (0mm, 0mm), closed, covered)
  gap_inner1.sweep_along_vector((0mm, 0mm, $copperthickness))

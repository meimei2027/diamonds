# Ansys Electronics Desktop project, version 2025.2
project variables:
  $smawidth = 2.8mm  # sensitivity 1.4mm..4.2mm
  $copperthickness = 0.0356mm  # sensitivity 0.0178mm..0.0534mm
  $substratethickness = 1.524mm  # sensitivity 0.762mm..2.286mm
  $lambda4 = 27mm
  $widthy = 76.2mm
  $taperextra = 0.05mm
  $tracelength = 0mm
  $tracewidth = 0.3mm  # sensitivity 0.15mm..0.45mm
  $tracecenterx = $gapwidth/2+$tracewidth/2
  $resistthickness = 0.03mm  # sensitivity 0.015mm..0.045mm
  $tracelength2 = $starty-$R
  $gapwidth = 0.2mm  # sensitivity 0.1mm..0.3mm
  $holerad = 0.5mm  # sensitivity 0.25mm..0.75mm
  $s = 2.5mm  # sensitivity 1.25mm..3.75mm
  $R = 8mm  # sensitivity 4mm..12mm
  $starty = 50mm
materials:
  vacuum: permittivity=1
  Isola FR408HR: permittivity=3.68 dielectric_loss_tangent=0.0092
  air: permittivity=1.0006 permeability=1.0000004
  FR4_epoxy: permittivity=4.6 dielectric_loss_tangent=0.03
  copper: permeability=0.999991 conductivity=58000000
  solder-resist: permittivity=3.4 dielectric_loss_tangent=0.025 delta_H_freq=2800000000
  SolderMask: permittivity=4.5 dielectric_loss_tangent=0.025

design HFSSDesign1 (HFSS, HFSS Terminal Network, model units mm)
geometry:
  substrate [FR4_epoxy] = box(corner=(-12.7mm, -$starty+$tracelength, 0mm), size=(25.4mm, $widthy-$tracelength, -$substratethickness))
  bigring [copper, solve inside] = cylinder(axis=Z, base_centre=(0mm, 0mm, 0mm), radius=$R, height=$copperthickness)
  smallring = cylinder(axis=Z, base_centre=(0mm, $s, 0mm), radius=$holerad, height=$copperthickness)
  bigring.subtract(smallring)
  gap = box(corner=(-$gapwidth/2, -$R, 0mm), size=($gapwidth, $R+$s, $copperthickness))
  bigring.subtract(gap)
  Polyline1 = polyline(z=0mm, xy: ($tracecenterx-$tracewidth/2, (-$R+$taperextra)) ($tracecenterx+$tracewidth/2, -$R+$taperextra) ($tracecenterx+$smawidth/2, (-$tracelength2-$R)) ($tracecenterx-$smawidth/2, (-$tracelength2-$R)) ($tracecenterx-$tracewidth/2, (-$R+$taperextra)), closed, covered)
  line = Polyline1.detach(Polyline1.face(at (0.25, -28.975, 0)))
  line.sweep_along_vector((0mm, 0mm, $copperthickness))
  bigring.unite(line)
  ground = rectangle(corner=(-12.7mm, -$starty+$tracelength, -$substratethickness), x_size=25.4mm, y_size=$widthy-$tracelength)
  radbox [air] = box(corner=(-((25.4+54)/2) mm, -$starty-$lambda4, -$lambda4), size=((25.4+54) mm, $widthy+$lambda4*2, $lambda4 *2))
  plane Plane1 = base (0mm, 0mm, (0.03+0.5) mm) normal (0mm, 0mm, 1mm)
  resist = box(corner=(-12.7mm, -$starty+$tracelength, 0), size=(25.4mm, $widthy-$tracelength, $copperthickness))
  bigring_2 = bigring.copy()
  resist.subtract(bigring_2)
  resist2 [SolderMask] = box(corner=(-12.7mm, -$starty+$tracelength, $copperthickness), size=(25.4mm, $widthy-$tracelength, 0.0152mm))
  resist2.unite(resist)
  port1 = rectangle(corner=($tracecenterx-$smawidth/2, -$R-$tracelength2, 0), z_size=-$substratethickness, x_size=$smawidth)
boundaries and excitations:
  ground: Perfect E Objects=ground
  antenna: Perfect E Objects=bigring
  radbox: Radiation Objects=radbox
  1: Lumped Port Objects=port1 LumpedPortType=Modal Modes{Mode1{IntLine{(0.25, -50, 0) -> (0.25, -50, -1.524)} CharImp=Zpi RenormImp=50ohm}} Impedance=50ohm
mesh:
  Length1: LengthBased Objects=bigring MaxLength=1.8mm
  Length2: LengthBased RefineInside Objects=resist2 MaxLength=5mm
  Length3: LengthBased Objects=port1 MaxLength=0.7mm
  initial mesh: GlobalSurfApproximation{CurvedSurfaceApproxChoice=UseSlider SliderMeshSettings=7} GlobalCurvilinear{Apply} DynamicSurfaceResolution
setups:
  Setup1: HfssDriven Frequency=2.87GHz MaxDeltaS=0.01 MaximumPasses=6 MinimumPasses=1 MinimumConvergedPasses=1 PercentRefinement=30 BasisOrder=1 PortAccuracy=2 DrivenSolverType="Direct Solver"
    sweep Sweep: 2.86GHz to 2.88GHz, 5 points; Type=Interpolating SaveFields InterpTolerance=0.5 InterpMaxSolns=250 PassivityErrorTolerance=0.0001
source amplitudes:
  1:1: 1V 0deg
optimetrics:
  SensitivitySetup1: Sensitivity MaxIterations=10 Primary_Goal=0 PrimaryError=0.0001
    calculate dB(St(1,1)) on Setup1 : Sweep at Freq 2.87437185929648GHz
field calculator expressions:
  test4 = <Hx,Hy,Hz> | Scalar_Function(FuncValue='Phase') | AtPhase | Normal | Dot
  test5 = test4 | Abs
field plots:
  test51: B_z [A/m] over a plane on Setup1 : Sweep at Freq=2.87GHz Phase=0deg
  Vector_H1: H Field in substrate on Setup1 : LastAdaptive at Freq=2.87GHz Phase=0deg
  Vector_H2: H Field in radbox on Setup1 : LastAdaptive at Freq=2.87GHz Phase=0deg
reports:
  S Parameter Plot1: dB(S(1,1)) vs Freq on Setup1 : Sweep [$tracewidth=0.3mm,0.5mm $s=2.5mm $R=8mm]; markers m1 at 2.8656566GHz, m2 at 2.8757576GHz, m3 at 2.8757576GHz
  Z Parameter Plot1: re(Z(1,1)), im(Z(1,1)) vs Freq on Setup1 : Sweep

# Ansys Electronics Desktop project, version 2025.2
project variables:
  $smawidth = 0.7mm
  $copperthickness = 0.0356mm
  $substratethickness = 1.524mm
  $lambda4 = 27mm
  $widthy = 50mm
  $taperextra = 0.05mm
  $tracelength = 0mm
  $tracewidth = 0.7mm
  $tracecenterx = $gapwidth/2+$tracewidth/2
  $resistthickness = 0.03mm
  $tracelength2 = 0.01mm
  $gapwidth = 0.2mm
  $holerad = 0.7mm
  $s = 3.9mm
materials:
  vacuum: permittivity=1
  Isola FR408HR: permittivity=3.68 dielectric_loss_tangent=0.0092
  air: permittivity=1.0006 permeability=1.0000004
  FR4_epoxy: permittivity=4.3 dielectric_loss_tangent=0.03
  copper: permeability=0.999991 conductivity=58000000
  solder-resist: permittivity=3.4 dielectric_loss_tangent=0.025 delta_H_freq=2800000000
  SolderMask: permittivity=4.5 dielectric_loss_tangent=0.025

design HFSSDesign1 (HFSS, HFSS Terminal Network, model units mm)
geometry:
  substrate [FR4_epoxy] = box(corner=(-12.7mm, -30mm+$tracelength, 0mm), size=(25.4mm, $widthy-$tracelength, -$substratethickness))
  bigring [copper, solve inside] = cylinder(axis=Z, base_centre=(0mm, 0mm, 0mm), radius=7mm, height=$copperthickness)
  smallring = cylinder(axis=Z, base_centre=(0mm, $s, 0mm), radius=$holerad, height=$copperthickness)
  bigring.subtract(smallring)
  gap = box(corner=(-$gapwidth/2, -7mm, 0mm), size=($gapwidth, 7mm+$s, $copperthickness))
  bigring.subtract(gap)
  Polyline1 = polyline(z=0mm, xy: ($tracecenterx-$tracewidth/2, (-7mm+$taperextra)) ($tracecenterx+$tracewidth/2, -7mm+$taperextra) ($tracecenterx+$smawidth/2, (-$tracelength2-7mm)) ($tracecenterx-$smawidth/2, (-$tracelength2-7mm)) ($tracecenterx-$tracewidth/2, (-7mm+$taperextra)), closed, covered)
  line = Polyline1.detach(Polyline1.face(at (0.45, -6.98, 0)))
  line.sweep_along_vector((0mm, 0mm, $copperthickness))
  bigring.unite(line)
  ground = rectangle(corner=(-12.7mm, -30mm+$tracelength, -1.6mm), x_size=25.4mm, y_size=$widthy-$tracelength)
  radbox [air] = box(corner=(-((25.4+54)/2) mm, -30mm-$lambda4, -$lambda4), size=((25.4+54) mm, $widthy+$lambda4*2, $lambda4 *2))
  plane Plane1 = base (0mm, 0mm, (0.03+0.5) mm) normal (0mm, 0mm, 1mm)
  port1 = rectangle(corner=($tracecenterx-$smawidth/2, -7mm-$tracelength2, 0), z_size=-$substratethickness, x_size=$smawidth)
boundaries and excitations:
  ground: Perfect E Objects=ground
  antenna: Perfect E Objects=bigring
  radbox: Radiation Objects=radbox
  1: Lumped Port Objects=port1 LumpedPortType=Modal Modes{Mode1{IntLine{(0.45, -7.01, 0) -> (0.45, -7.01, -1.524)} CharImp=Zpi RenormImp=50ohm}} Impedance=50ohm
mesh:
  Length1: LengthBased Objects=bigring MaxLength=1.8mm
  Length3: LengthBased Objects=port1 MaxLength=0.7mm
  initial mesh: GlobalSurfApproximation{CurvedSurfaceApproxChoice=UseSlider SliderMeshSettings=7} GlobalCurvilinear{Apply} DynamicSurfaceResolution
setups:
  Setup1: HfssDriven Frequency=2.9GHz MaxDeltaS=0.01 MaximumPasses=6 MinimumPasses=1 MinimumConvergedPasses=1 PercentRefinement=30 BasisOrder=1 PortAccuracy=2 DrivenSolverType="Direct Solver"
    sweep Sweep: 2GHz to 4GHz, 200 points; Type=Interpolating SaveFields InterpTolerance=0.5 InterpMaxSolns=250 PassivityErrorTolerance=0.0001
source amplitudes:
  1:1: 1V 0deg
optimetrics:
  SensitivitySetup1: Sensitivity MaxIterations=10 Primary_Goal=-1 PrimaryError=0.0001
    calculate dB(St(1,1)) on Setup1 : Sweep at Freq 2.87437185929648GHz
  ParametricSetup1: Parametric Sim._Setups=[Setup1]
    sweep $s: LIN 2mm 5mm 1mm
field calculator expressions:
  test4 = <Hx,Hy,Hz> | Scalar_Function(FuncValue='Phase') | AtPhase | Normal | Dot
  test5 = test4 | Abs
field plots:
  test51: NamedExpr over a plane on Setup1 : Sweep at Freq=3GHz Phase=0deg
reports:
  S Parameter Plot1: dB(S(1,1)) vs Freq on Setup1 : Sweep [$s=2mm,3mm,3.9mm,4mm,5mm]; markers m1 at 2.7135678GHz, m2 at 3.1658291GHz, m3 at 3.1356784GHz, m4 at 3.2060302GHz
  Z Parameter Plot1: re(Z(1,1)), im(Z(1,1)) vs Freq on Setup1 : Sweep; markers m1 at 2.7939698GHz, m2 at 2.7839196GHz, m3 at 2.7939698GHz
